// Design: master_research/nmos_ota_opt
simulator lang=spectre
global 0 vdd!
parameters VDD=1.2 Vincm=0.6 cL=5e-12 L34=4.77617984921e-07 W34=2.21052305948e-05 L12=6.13023197793e-07 W12=0.000239367506412 Itail=0.000171123359276
include "/home/cadence/Desktop/PDK_CRN65LP_v1.7a_Official_IC61_20120914_all/PDK_CRN65LP_v1.7a_Official_IC61_20120914/tsmcN65/../models/spectre/toplevel.scs" section=tt_lib

// analogLib/ideal_balun/schematic
subckt ideal_balun d c p n
    K0 (d 0 p c) transformer n1=2
    K1 (d 0 c n) transformer n1=2
ends ideal_balun

// master_research/nmos_ota_opt/schematic
V4 (vdd! 0) vsource dc=VDD type=dc
V5 (net8 0) vsource dc=Vincm type=dc
V8 (Vin 0) vsource mag=1 type=dc
I16 (Vin net8 Vin\+ Vin\-) ideal_balun
C0 (Vout 0) capacitor c=cL
M1 (net04 net04 vdd! vdd!) pch l=L34 w=W34*1 m=1 nf=1
M0 (Vout net04 vdd! vdd!) pch l=L34 w=W34*1 m=1 nf=1
M9 (net04 Vin\+ net02 0) nch l=L12 w=W12*1 m=1 nf=1
M8 (Vout Vin\- net02 0) nch l=L12 w=W12*1 m=1 nf=1
I26 (net02 0) isource dc=Itail type=dc
simulatorOptions options temp=27
// ANALOG_AI_CORRELATION_ANALYSES
dcCorr dc
acCorr ac start=1 stop=10G dec=30
save Vout net02 net04 vdd! Vin\+ Vin\-
dcCorrInfo info what=oppoint where=rawfile
// END_ANALOG_AI_CORRELATION_ANALYSES
