/* Phase F5 finite-M5 measurements for finite_manual_reference_001. */
openResults("./psf")
selectResult('ac)
gain = v("vout") / (v("vin_p") - v("vin_n"))
gainDbWave = db20(gain)
phaseWave = phase(gain)
gainDb = value(gainDbWave 1.0)
ugf = cross(gainDbWave 0.0 1 "falling")
bw3 = cross(gainDbWave (gainDb - 3.0) 1 "falling")
phaseAtUgf = value(phaseWave ugf)
phaseMargin = 180.0 + phaseAtUgf

selectResult('dc)
voutDc = v("vout")
vtailDc = v("vtail")
vmirrorDc = v("vmirror")
vddCurrent = i("VDDsrc:p")
powerDc = 1.2 * abs(vddCurrent)

selectResult('finiteOpInfo)
printf("ANALOG_AI_FINITE_OP_OUTPUTS_BEGIN\n")
printf("%L\n" outputs())
printf("ANALOG_AI_FINITE_OP_OUTPUTS_END\n")
m1Id = abs(OP("/M1" "id"))
m1Gm = abs(OP("/M1" "gm"))
m1Gds = abs(OP("/M1" "gds"))
m1Gmbs = abs(OP("/M1" "gmbs"))
m1Vdsat = abs(OP("/M1" "vdsat"))
m1Vds = abs(OP("/M1" "vds"))
m2Id = abs(OP("/M2" "id"))
m2Gm = abs(OP("/M2" "gm"))
m2Gds = abs(OP("/M2" "gds"))
m2Gmbs = abs(OP("/M2" "gmbs"))
m2Vdsat = abs(OP("/M2" "vdsat"))
m2Vds = abs(OP("/M2" "vds"))
m3Id = abs(OP("/M3" "id"))
m3Gm = abs(OP("/M3" "gm"))
m3Gds = abs(OP("/M3" "gds"))
m3Gmbs = abs(OP("/M3" "gmbs"))
m3Vdsat = abs(OP("/M3" "vdsat"))
m3Vds = abs(OP("/M3" "vds"))
m4Id = abs(OP("/M4" "id"))
m4Gm = abs(OP("/M4" "gm"))
m4Gds = abs(OP("/M4" "gds"))
m4Gmbs = abs(OP("/M4" "gmbs"))
m4Vdsat = abs(OP("/M4" "vdsat"))
m4Vds = abs(OP("/M4" "vds"))
m5Id = abs(OP("/M5" "id"))
m5Gm = abs(OP("/M5" "gm"))
m5Gds = abs(OP("/M5" "gds"))
m5Gmbs = abs(OP("/M5" "gmbs"))
m5Vdsat = abs(OP("/M5" "vdsat"))
m5Vds = abs(OP("/M5" "vds"))

printf("ANALOG_AI_FINITE_METRICS "
       "%.15g %.15g %.15g %.15g %.15g %.15g %.15g %.15g %.15g %.15g "
       "%.15g %.15g %.15g %.15g %.15g %.15g %.15g %.15g %.15g %.15g %.15g %.15g %.15g %.15g %.15g %.15g %.15g %.15g %.15g %.15g %.15g %.15g %.15g %.15g %.15g %.15g %.15g %.15g %.15g %.15g\n"
       gainDb bw3 ugf phaseAtUgf phaseMargin voutDc vtailDc vmirrorDc
       vddCurrent powerDc m1Id m1Gm m1Gds m1Gmbs m1Vdsat m1Vds m2Id m2Gm m2Gds m2Gmbs m2Vdsat m2Vds m3Id m3Gm m3Gds m3Gmbs m3Vdsat m3Vds m4Id m4Gm m4Gds m4Gmbs m4Vdsat m4Vds m5Id m5Gm m5Gds m5Gmbs m5Vdsat m5Vds)
exit()
