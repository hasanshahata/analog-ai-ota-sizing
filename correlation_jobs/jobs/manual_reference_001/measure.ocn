/* Generated by analog_ai for manual_reference_001. */
openResults("./psf")
printf("ANALOG_AI_RESULTS_BEGIN\n")
printf("%L\n" results())
printf("ANALOG_AI_RESULTS_END\n")

selectResult('ac)
printf("ANALOG_AI_AC_OUTPUTS_BEGIN\n")
printf("%L\n" outputs())
printf("ANALOG_AI_AC_OUTPUTS_END\n")
gain = v("Vout") / (v("Vin+") - v("Vin-"))
gainDbWave = db20(gain)
phaseWave = phase(gain)
gainDb = value(gainDbWave 1.0)
ugf = cross(gainDbWave 0.0 1 "falling")
bw3 = cross(gainDbWave (gainDb - 3.0) 1 "falling")
phaseAtUgf = value(phaseWave ugf)
phaseMargin = 180.0 + phaseAtUgf

selectResult('dc)
printf("ANALOG_AI_DC_OUTPUTS_BEGIN\n")
printf("%L\n" outputs())
printf("ANALOG_AI_DC_OUTPUTS_END\n")
voutDc = v("Vout")
vtailDc = v("net02")
vmirrorDc = v("net04")
vddCurrent = i("V4:p")
powerDc = 1.2 * abs(vddCurrent)

/* stdout is captured by the guest runner. Avoid OCEAN-side file output
 * because this old IC617 build does not reliably write on VMware hgfs. */
printf("ANALOG_AI_METRICS %.15g %.15g %.15g %.15g %.15g %.15g %.15g %.15g %.15g %.15g\n"
       gainDb bw3 ugf phaseAtUgf phaseMargin voutDc vtailDc vmirrorDc
       vddCurrent powerDc)
exit()
